* SPICE3 file created from opamp.ext - technology: sky130A

.subckt sky130_fd_pr__nfet_g5v0d10v5_YBGU8J B D S G
X0 S G D B sky130_fd_pr__nfet_g5v0d10v5 ad=17.4 pd=120.58 as=17.4 ps=120.58 w=60 l=1.25
C0 G D 1.48154f
C1 S D 2.74418f
C2 S G 1.48154f
C3 S B 6.51372f
C4 D B 6.38631f
C5 G B 0.66103f
.ends

.subckt sky130_fd_pr__pfet_g5v0d10v5_XJDP5E w_n348_n2262# a_n148_n1964# a_90_n1964#
+ a_n90_n2061# VSUBS
X0 a_90_n1964# a_n90_n2061# a_n148_n1964# w_n348_n2262# sky130_fd_pr__pfet_g5v0d10v5 ad=5.8 pd=40.58 as=5.8 ps=40.58 w=20 l=0.9
C0 w_n348_n2262# a_n90_n2061# 0.21416f
C1 a_n148_n1964# a_90_n1964# 1.18384f
C2 a_n148_n1964# a_n90_n2061# 0.40254f
C3 a_90_n1964# a_n90_n2061# 0.40254f
C4 a_n148_n1964# w_n348_n2262# 0.28938f
C5 a_90_n1964# w_n348_n2262# 0.28938f
C6 a_90_n1964# VSUBS 1.63819f
C7 a_n148_n1964# VSUBS 1.63819f
C8 a_n90_n2061# VSUBS 0.25485f
C9 w_n348_n2262# VSUBS 9.58928f
.ends

.subckt sky130_fd_pr__pfet_g5v0d10v5_HEFLWT B D S G VSUBS
X0 S G D B sky130_fd_pr__pfet_g5v0d10v5 ad=46.4 pd=320.57999 as=46.4 ps=320.57999 w=160 l=1.25
C0 B G 0.37069f
C1 D S 7.31638f
C2 D G 3.94102f
C3 S G 3.94102f
C4 D B 9.00947f
C5 S B 9.00947f
C6 S VSUBS 8.10829f
C7 D VSUBS 8.10829f
C8 G VSUBS 0.29709f
C9 B VSUBS 91.0196f
.ends

.subckt sky130_fd_pr__nfet_g5v0d10v5_3TRZRB B D S G
X0 S G D B sky130_fd_pr__nfet_g5v0d10v5 ad=17.4 pd=120.58 as=17.4 ps=120.58 w=60 l=1.25
C0 G D 1.48154f
C1 S D 2.74418f
C2 S G 1.48154f
C3 S B 6.38631f
C4 D B 6.51372f
C5 G B 0.66103f
.ends

.subckt sky130_fd_pr__pfet_g5v0d10v5_GM3SG7 B D S G VSUBS
X0 S G D B sky130_fd_pr__pfet_g5v0d10v5 ad=21.808 pd=150.98 as=21.808 ps=150.98 w=75.2 l=1.25
C0 B G 0.376f
C1 D S 3.43915f
C2 D G 1.85538f
C3 S G 1.85538f
C4 D B 4.41351f
C5 S B 4.25168f
C6 S VSUBS 3.81562f
C7 D VSUBS 3.81562f
C8 G VSUBS 0.29709f
C9 B VSUBS 42.063f
.ends

.subckt sky130_fd_pr__pfet_g5v0d10v5_TL3SGF B D S G VSUBS
X0 S G D B sky130_fd_pr__pfet_g5v0d10v5 ad=21.808 pd=150.98 as=21.808 ps=150.98 w=75.2 l=1.25
C0 B G 0.376f
C1 D S 3.43915f
C2 D G 1.85538f
C3 S G 1.85538f
C4 D B 4.41351f
C5 S B 4.25168f
C6 S VSUBS 3.81562f
C7 D VSUBS 3.81562f
C8 G VSUBS 0.29709f
C9 B VSUBS 42.063f
.ends

.subckt sky130_fd_pr__nfet_g5v0d10v5_KXYP2B B D S G
X0 S G D B sky130_fd_pr__nfet_g5v0d10v5 ad=11.02 pd=76.58 as=11.02 ps=76.58 w=38 l=0.5
C0 G D 0.47467f
C1 S D 3.37805f
C2 S G 0.47467f
C3 S B 3.76091f
C4 D B 3.8416f
C5 G B 0.31962f
.ends

.subckt sky130_fd_pr__nfet_g5v0d10v5_F3XVAM B D S G
X0 S G D B sky130_fd_pr__nfet_g5v0d10v5 ad=11.02 pd=76.58 as=11.02 ps=76.58 w=38 l=0.5
C0 G D 0.47467f
C1 S D 3.37805f
C2 S G 0.47467f
C3 S B 3.76091f
C4 D B 3.8416f
C5 G B 0.31962f
.ends

.subckt sky130_fd_pr__nfet_g5v0d10v5_YB4TWH B D S G
X0 S G D B sky130_fd_pr__nfet_g5v0d10v5 ad=17.4 pd=120.58 as=17.4 ps=120.58 w=60 l=1.25
C0 G D 1.48154f
C1 S D 2.74418f
C2 S G 1.48154f
C3 S B 6.51372f
C4 D B 6.38631f
C5 G B 0.66103f
.ends

.subckt sky130_fd_pr__cap_mim_m3_1_BTG3QK C2 C1 VSUBS
X0 C1 C2 sky130_fd_pr__cap_mim_m3_1 l=25 w=25
X1 C1 C2 sky130_fd_pr__cap_mim_m3_1 l=25 w=25
X2 C1 C2 sky130_fd_pr__cap_mim_m3_1 l=25 w=25
X3 C1 C2 sky130_fd_pr__cap_mim_m3_1 l=25 w=25
X4 C1 C2 sky130_fd_pr__cap_mim_m3_1 l=25 w=25
X5 C1 C2 sky130_fd_pr__cap_mim_m3_1 l=25 w=25
X6 C1 C2 sky130_fd_pr__cap_mim_m3_1 l=25 w=25
X7 C1 C2 sky130_fd_pr__cap_mim_m3_1 l=25 w=25
C0 C2 C1 0.44374p
C1 C1 VSUBS 11.8598f
C2 C2 VSUBS 99.4744f
.ends

.subckt opamp VP VN IBIAS OUT VDD VSS
XXM23 VSS XM6/S VSS IBIAS sky130_fd_pr__nfet_g5v0d10v5_YBGU8J
Xsky130_fd_pr__pfet_g5v0d10v5_XJDP5E_0 VDD OUT XC1/C1 VSS VSS sky130_fd_pr__pfet_g5v0d10v5_XJDP5E
XXM27 VDD OUT VDD XM5/D VSS sky130_fd_pr__pfet_g5v0d10v5_HEFLWT
XXM28 VSS OUT VSS IBIAS sky130_fd_pr__nfet_g5v0d10v5_3TRZRB
XXM1 VDD XM5/D VDD XM6/D VSS sky130_fd_pr__pfet_g5v0d10v5_GM3SG7
XXM2 VDD XM6/D VDD XM6/D VSS sky130_fd_pr__pfet_g5v0d10v5_TL3SGF
XXM5 VSS XM5/D XM6/S VN sky130_fd_pr__nfet_g5v0d10v5_KXYP2B
XXM6 VSS XM6/D XM6/S VP sky130_fd_pr__nfet_g5v0d10v5_F3XVAM
Xsky130_fd_pr__nfet_g5v0d10v5_YB4TWH_0 VSS IBIAS VSS IBIAS sky130_fd_pr__nfet_g5v0d10v5_YB4TWH
XXC1 XM5/D XC1/C1 VSS sky130_fd_pr__cap_mim_m3_1_BTG3QK
C0 VP VN 0.0848f
C1 OUT IBIAS 0.02474f
C2 OUT XM6/D 4.91861f
C3 OUT VDD 15.25575f
C4 OUT XM6/S 0
C5 XM6/D IBIAS 0.00206f
C6 OUT VN 3.25901f
C7 OUT XM5/D 4.44676f
C8 VDD IBIAS 0.01403f
C9 XM6/S IBIAS 4.94526f
C10 IBIAS VN 0.00537f
C11 XM6/D VDD 2.00189f
C12 XM6/D XM6/S 0.21525f
C13 XM5/D IBIAS 0.04013f
C14 XM6/D VN 1.31272f
C15 XM6/S VDD 0.00177f
C16 XM6/D XM5/D 0.07194f
C17 VDD VN 0.1402f
C18 XM6/S VN 0.08144f
C19 XM5/D VDD 55.21125f
C20 XM6/S XM5/D 0.00106f
C21 OUT XC1/C1 -0.0152f
C22 XM5/D VN 1.34766f
C23 XC1/C1 IBIAS 0
C24 XM6/D XC1/C1 0
C25 OUT VP 0
C26 VDD XC1/C1 4.66888f
C27 VP IBIAS 0.0251f
C28 XM5/D XC1/C1 1.9369f
C29 XM6/D VP 0.06934f
C30 VDD VP 0.00196f
C31 XM6/S VP -0.02876f
C32 XM6/S VSS 12.6286f
C33 XM6/D VSS 6.87887f
C34 VP VSS 0.60488f
C35 XM5/D VSS 0.10432p
C36 VN VSS 1.8368f
C37 VDD VSS 0.22089p
C38 OUT VSS 14.45746f
C39 XC1/C1 VSS 13.74829f
C40 IBIAS VSS 25.30641f
.ends
