** sch_path: /foss/designs/kerjapraktik/test/ldo/xschem/integrasi/cap.sch
.subckt cap

XC2 net1 net2 sky130_fd_pr__cap_mim_m3_1 W=25 L=25 m=8
.ends
